* +++++++++++++++++++++++++++++++++++++++++++++++++++++++++ *
* CDL Netlist:                                              *
*                                                           *
* Cell Name  : nand2                                        *
* Netlisted  : Mon Jun 22 16:06:09 2026                     *
* PVS Version: 22.20-p031 Thu Nov 17 19:06:38 PST 2022      *
* +++++++++++++++++++++++++++++++++++++++++++++++++++++++++ *
*.LDD
*.DEVTMPLT 0 MN(n1svt) n1svt_dev nsd(D) ngate(G) nsd(S) psub(B)
*.DEVTMPLT 1 MP(p1svt) p1svt_dev psd(D) pgate(G) psd(S) nw_conn(B)

* +++++++++++++++++++++++++++++++++++++++++++++++++++++++++ *
* Sub cell: M2_M1_CDNS_1                                    *
* +++++++++++++++++++++++++++++++++++++++++++++++++++++++++ *
.subckt M2_M1_CDNS_1 1
** N=1 EP=1 FDC=0
.ends M2_M1_CDNS_1

* +++++++++++++++++++++++++++++++++++++++++++++++++++++++++ *
* Sub cell: M1_LiAct_CDNS_2                                 *
* +++++++++++++++++++++++++++++++++++++++++++++++++++++++++ *
.subckt M1_LiAct_CDNS_2 1
** N=1 EP=1 FDC=0
.ends M1_LiAct_CDNS_2

* +++++++++++++++++++++++++++++++++++++++++++++++++++++++++ *
* Sub cell: nwellTap_CDNS_3                                 *
* +++++++++++++++++++++++++++++++++++++++++++++++++++++++++ *
.subckt nwellTap_CDNS_3 1
** N=1 EP=1 FDC=0
.ends nwellTap_CDNS_3

* +++++++++++++++++++++++++++++++++++++++++++++++++++++++++ *
* Sub cell: n1svt_CDNS_5                                    *
* +++++++++++++++++++++++++++++++++++++++++++++++++++++++++ *
.subckt n1svt_CDNS_5 1 2 3 4
** N=10 EP=4 FDC=1
M0 3 1 2 4 n1svt L=1.8e-08 nf=1 nfin=4 asej=3.808e-15 adej=3.808e-15 psej=6e-07 pdej=6e-07 $X=0 $Y=0 $dt=0
.ends n1svt_CDNS_5

* +++++++++++++++++++++++++++++++++++++++++++++++++++++++++ *
* Sub cell: p1svt_CDNS_6                                    *
* +++++++++++++++++++++++++++++++++++++++++++++++++++++++++ *
.subckt p1svt_CDNS_6 1 2 3 4
** N=10 EP=4 FDC=1
M0 3 1 2 2 p1svt L=1.8e-08 nf=1 nfin=2 asej=1.904e-15 adej=1.904e-15 psej=3e-07 pdej=3e-07 $X=0 $Y=0 $dt=1
.ends p1svt_CDNS_6

* +++++++++++++++++++++++++++++++++++++++++++++++++++++++++ *
* Sub cell: nand2                                           *
* +++++++++++++++++++++++++++++++++++++++++++++++++++++++++ *
.subckt nand2 6 3 1 5 2
** N=6 EP=5 FDC=4
X0 1 M2_M1_CDNS_1 $T=608 1360 0 180 $X=556 $Y=1328
X1 1 M2_M1_CDNS_1 $T=608 1662 0 180 $X=556 $Y=1630
X2 2 M1_LiAct_CDNS_2 $T=806 3376 0 0 $X=694 $Y=3308
X3 3 M1_LiAct_CDNS_2 $T=978 2200 0 0 $X=866 $Y=2132
X4 4 M1_LiAct_CDNS_2 $T=1242 1320 0 0 $X=1130 $Y=1252
X5 4 M1_LiAct_CDNS_2 $T=1414 1320 0 0 $X=1302 $Y=1252
X6 3 M1_LiAct_CDNS_2 $T=1414 2200 0 0 $X=1302 $Y=2132
X7 2 M1_LiAct_CDNS_2 $T=2018 3372 0 0 $X=1906 $Y=3304
X8 3 M1_LiAct_CDNS_2 $T=2190 2200 0 0 $X=2078 $Y=2132
X9 2 nwellTap_CDNS_3 $T=806 3376 0 0 $X=648 $Y=3184
X10 2 nwellTap_CDNS_3 $T=2018 3372 0 0 $X=1860 $Y=3180
X11 1 5 4 5 n1svt_CDNS_5 $T=1310 738 0 0 $X=794 $Y=542
X12 6 4 3 5 n1svt_CDNS_5 $T=1310 1656 0 0 $X=794 $Y=1460
X13 6 2 3 5 p1svt_CDNS_6 $T=874 2578 0 0 $X=358 $Y=2448
X14 1 2 3 5 p1svt_CDNS_6 $T=2086 2578 0 0 $X=1570 $Y=2448
.ends nand2
